.lib "~/tools/pdk/sky130A/libs.tech/ngspice/sky130.lib.spice" tt
.include ../layouts/cmos-inverter.spice

X1 out in vdd 0 cmos-inverter

Vdd vdd 0 1.8
Vin in 0 pulse(0 1.8 1n 10p 10p 4n 10n)

.tran 10p 20n

.control
    run
    wrdata inverter-testbench-curves.dat v(in) v(out)
.endc

.end
